* A 10 V source and a 1:1 resistor divider.
V1 in 0 10
R1 in out 1k
R2 out 0 1k
